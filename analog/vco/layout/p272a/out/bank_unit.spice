* P2.7.2a3 bank_unit LSB [SCH]
.subckt bank_unit tp tn g vbp bb gnd
Cxb tp a cap_cmim w=2.81e-06 l=2.81e-06 m=1
Cxn tn b cap_cmim w=2.81e-06 l=2.81e-06 m=1
Mms a g b gnd sg13_lv_nmos w=10.32u l=0.13u
Rrba a bb gnd rhigh w=5.0u l=60.8u m=1
Rrbb b bb gnd rhigh w=5.0u l=60.8u m=1
Mbp_a a vbp bb gnd sg13_lv_nmos w=0.15u l=0.13u
Mbp_b b vbp bb gnd sg13_lv_nmos w=0.15u l=0.13u
.ends
