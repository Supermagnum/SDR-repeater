* Extracted by KLayout with SG13G2 LVS runset on : 12/11/2026 11:27

.SUBCKT bank_unit bb g gnd tn tp vbp
M$1 bb vbp \$6 gnd sg13_lv_nmos L=0.13u W=0.15u AS=0.1005p AD=0.1005p PS=1.34u
+ PD=1.34u rfmode=0
M$2 \$5 vbp bb gnd sg13_lv_nmos L=0.13u W=0.15u AS=0.1005p AD=0.1005p PS=1.34u
+ PD=1.34u rfmode=0
M$3 \$6 g \$5 gnd sg13_lv_nmos L=0.13u W=10.32u AS=2.7348p AD=2.7348p PS=16.54u
+ PD=16.54u rfmode=0
R$5 bb \$6 gnd rhigh w=5u l=60.8u ps=0u b=0 m=1
R$6 bb \$5 gnd rhigh w=5u l=60.8u ps=0u b=0 m=1
C$7 tp \$6 cap_cmim w=2.81u l=2.81u A=7.8961p P=11.24u m=1
C$8 tn \$5 cap_cmim w=2.81u l=2.81u A=7.8961p P=11.24u m=1
.ENDS bank_unit
