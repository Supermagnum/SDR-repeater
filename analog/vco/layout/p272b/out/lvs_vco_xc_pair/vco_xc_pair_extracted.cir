* Extracted by KLayout with SG13G2 LVS runset on : 12/11/2026 14:39

.SUBCKT vco_xc_pair gnd tail tn tp
M$1 gnd gnd gnd gnd sg13_lv_nmos L=0.13u W=8u AS=2.72p AD=2.72p PS=17.36u
+ PD=17.36u rfmode=0
M$2 tp tn tail gnd sg13_lv_nmos L=0.13u W=32u AS=6.68p AD=6.68p PS=39.34u
+ PD=39.34u rfmode=0
M$10 tn tp tail gnd sg13_lv_nmos L=0.13u W=32u AS=6.68p AD=6.68p PS=39.34u
+ PD=39.34u rfmode=0
.ENDS vco_xc_pair
