* P2.7.2b cbf: 7× cmim [SCH cbf0..6]; LVS m=7 @ 68.94u [GDS extract]
.subckt cbf nbf gnd
Ccbf nbf gnd cap_cmim w=68.94u l=68.94u m=7
.ends
