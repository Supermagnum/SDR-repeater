* P2.7.2b dac_unit W=2u L=2u [SCH] Pelgrom KEEP
.subckt dac_unit vdd pbias xd code xraw
Mmdb xd pbias vdd vdd sg13_lv_pmos w=2.0u l=2.0u
Mmsw xraw code xd vdd sg13_lv_pmos w=2.0u l=0.13u
.ends
