* Extracted by KLayout with SG13G2 LVS runset on : 13/11/2026 11:52

.SUBCKT d9_rc nb nbf
M$1 nb \$8 nbf nb sg13_lv_nmos L=0.13u W=20u AS=4.55p AD=4.55p PS=26.82u
+ PD=26.82u rfmode=0
R$5 nb nbf nb rhigh w=0.5u l=354u ps=0u b=0 m=1
.ENDS d9_rc
