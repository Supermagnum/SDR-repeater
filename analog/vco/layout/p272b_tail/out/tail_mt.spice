* P2.7.2b tail_mt W=480u L=4u ng=96 as 4× (120u/4u ng=24) [SCH amp_common]
.subckt tail_mt tail nbf gnd
Mmt0 tail nbf gnd gnd sg13_lv_nmos w=120.0u l=4.0u ng=24
Mmt1 tail nbf gnd gnd sg13_lv_nmos w=120.0u l=4.0u ng=24
Mmt2 tail nbf gnd gnd sg13_lv_nmos w=120.0u l=4.0u ng=24
Mmt3 tail nbf gnd gnd sg13_lv_nmos w=120.0u l=4.0u ng=24
.ends
