* Extracted by KLayout with SG13G2 LVS runset on : 13/11/2026 04:39

.SUBCKT dac_unit code pbias vdd xd xraw
M$1 xd pbias vdd vdd sg13_lv_pmos L=2u W=2u AS=0.68p AD=0.68p PS=4.68u PD=4.68u
+ rfmode=0
M$2 xraw code xd vdd sg13_lv_pmos L=0.13u W=2u AS=0.68p AD=0.68p PS=4.68u
+ PD=4.68u rfmode=0
.ENDS dac_unit
