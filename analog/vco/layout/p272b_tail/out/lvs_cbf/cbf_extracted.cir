* Extracted by KLayout with SG13G2 LVS runset on : 14/11/2026 15:18

.SUBCKT cbf gnd nbf
C$1 nbf gnd cap_cmim w=68.94u l=68.94u A=4752.7236p P=275.76u m=7
.ENDS cbf
