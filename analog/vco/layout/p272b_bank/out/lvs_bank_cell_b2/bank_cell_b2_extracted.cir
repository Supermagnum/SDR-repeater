* Extracted by KLayout with SG13G2 LVS runset on : 12/11/2026 16:08

.SUBCKT bank_cell_b2 bb g gnd tn tp vbp
M$1 bb vbp \$6 gnd sg13_lv_nmos L=0.13u W=0.15u AS=0.1005p AD=0.1005p PS=1.34u
+ PD=1.34u rfmode=0
M$2 \$5 vbp bb gnd sg13_lv_nmos L=0.13u W=0.15u AS=0.1005p AD=0.1005p PS=1.34u
+ PD=1.34u rfmode=0
M$3 \$6 g \$5 gnd sg13_lv_nmos L=0.13u W=39.12u AS=7.79955p AD=7.79955p
+ PS=47.945u PD=47.945u rfmode=0
R$19 bb \$6 gnd rhigh w=5u l=60.8u ps=0u b=0 m=1
R$20 bb \$5 gnd rhigh w=5u l=60.8u ps=0u b=0 m=1
C$21 tp \$6 cap_cmim w=5.53u l=5.53u A=30.5809p P=22.12u m=1
C$22 tn \$5 cap_cmim w=5.53u l=5.53u A=30.5809p P=22.12u m=1
.ENDS bank_cell_b2
