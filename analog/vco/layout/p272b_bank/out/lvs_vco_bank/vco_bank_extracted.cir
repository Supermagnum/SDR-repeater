* Extracted by KLayout with SG13G2 LVS runset on : 12/11/2026 16:33

.SUBCKT vco_bank bb0 bb1 bb10 bb11 bb2 bb3 bb4 bb5 bb6 bb7 bb8 bb9 g0 g1 g10
+ g11 g2 g3 g4 g5 g6 g7 g8 g9 gnd tn tp vbp
M$1 bb5 vbp \$14 gnd sg13_lv_nmos L=0.13u W=1.25u AS=0.425p AD=0.425p PS=3.18u
+ PD=3.18u rfmode=0
M$2 \$14 g5 \$11 gnd sg13_lv_nmos L=0.13u W=308.5u AS=59.07775p AD=59.07775p
+ PS=349.885u PD=349.885u rfmode=0
M$102 \$11 vbp bb5 gnd sg13_lv_nmos L=0.13u W=1.25u AS=0.425p AD=0.425p
+ PS=3.18u PD=3.18u rfmode=0
M$103 bb6 vbp \$15 gnd sg13_lv_nmos L=0.13u W=1.25u AS=0.425p AD=0.425p
+ PS=3.18u PD=3.18u rfmode=0
M$104 \$15 g6 \$12 gnd sg13_lv_nmos L=0.13u W=308.5u AS=59.07775p AD=59.07775p
+ PS=349.885u PD=349.885u rfmode=0
M$204 \$12 vbp bb6 gnd sg13_lv_nmos L=0.13u W=1.25u AS=0.425p AD=0.425p
+ PS=3.18u PD=3.18u rfmode=0
M$205 bb7 vbp \$16 gnd sg13_lv_nmos L=0.13u W=1.25u AS=0.425p AD=0.425p
+ PS=3.18u PD=3.18u rfmode=0
M$206 \$16 g7 \$13 gnd sg13_lv_nmos L=0.13u W=308.5u AS=59.07775p AD=59.07775p
+ PS=349.885u PD=349.885u rfmode=0
M$306 \$13 vbp bb7 gnd sg13_lv_nmos L=0.13u W=1.25u AS=0.425p AD=0.425p
+ PS=3.18u PD=3.18u rfmode=0
M$307 bb8 vbp \$85 gnd sg13_lv_nmos L=0.13u W=1.25u AS=0.425p AD=0.425p
+ PS=3.18u PD=3.18u rfmode=0
M$308 \$85 g8 \$81 gnd sg13_lv_nmos L=0.13u W=308.5u AS=59.07775p AD=59.07775p
+ PS=349.885u PD=349.885u rfmode=0
M$408 \$81 vbp bb8 gnd sg13_lv_nmos L=0.13u W=1.25u AS=0.425p AD=0.425p
+ PS=3.18u PD=3.18u rfmode=0
M$409 bb9 vbp \$86 gnd sg13_lv_nmos L=0.13u W=1.25u AS=0.425p AD=0.425p
+ PS=3.18u PD=3.18u rfmode=0
M$410 \$86 g9 \$82 gnd sg13_lv_nmos L=0.13u W=308.5u AS=59.07775p AD=59.07775p
+ PS=349.885u PD=349.885u rfmode=0
M$510 \$82 vbp bb9 gnd sg13_lv_nmos L=0.13u W=1.25u AS=0.425p AD=0.425p
+ PS=3.18u PD=3.18u rfmode=0
M$511 bb10 vbp \$87 gnd sg13_lv_nmos L=0.13u W=1.25u AS=0.425p AD=0.425p
+ PS=3.18u PD=3.18u rfmode=0
M$512 \$87 g10 \$83 gnd sg13_lv_nmos L=0.13u W=308.5u AS=59.07775p AD=59.07775p
+ PS=349.885u PD=349.885u rfmode=0
M$612 \$83 vbp bb10 gnd sg13_lv_nmos L=0.13u W=1.25u AS=0.425p AD=0.425p
+ PS=3.18u PD=3.18u rfmode=0
M$613 bb11 vbp \$88 gnd sg13_lv_nmos L=0.13u W=1.25u AS=0.425p AD=0.425p
+ PS=3.18u PD=3.18u rfmode=0
M$614 \$88 g11 \$84 gnd sg13_lv_nmos L=0.13u W=308.5u AS=59.07775p AD=59.07775p
+ PS=349.885u PD=349.885u rfmode=0
M$714 \$84 vbp bb11 gnd sg13_lv_nmos L=0.13u W=1.25u AS=0.425p AD=0.425p
+ PS=3.18u PD=3.18u rfmode=0
M$715 bb0 vbp \$174 gnd sg13_lv_nmos L=0.13u W=0.15u AS=0.1005p AD=0.1005p
+ PS=1.34u PD=1.34u rfmode=0
M$716 \$174 g0 \$169 gnd sg13_lv_nmos L=0.13u W=10.32u AS=2.3478p AD=2.3478p
+ PS=14.72u PD=14.72u rfmode=0
M$720 \$169 vbp bb0 gnd sg13_lv_nmos L=0.13u W=0.15u AS=0.1005p AD=0.1005p
+ PS=1.34u PD=1.34u rfmode=0
M$721 bb1 vbp \$175 gnd sg13_lv_nmos L=0.13u W=0.15u AS=0.1005p AD=0.1005p
+ PS=1.34u PD=1.34u rfmode=0
M$722 \$175 g1 \$170 gnd sg13_lv_nmos L=0.13u W=19.8u AS=4.13325p AD=4.13325p
+ PS=25.615u PD=25.615u rfmode=0
M$730 \$170 vbp bb1 gnd sg13_lv_nmos L=0.13u W=0.15u AS=0.1005p AD=0.1005p
+ PS=1.34u PD=1.34u rfmode=0
M$731 bb2 vbp \$176 gnd sg13_lv_nmos L=0.13u W=0.15u AS=0.1005p AD=0.1005p
+ PS=1.34u PD=1.34u rfmode=0
M$732 \$176 g2 \$171 gnd sg13_lv_nmos L=0.13u W=39.12u AS=7.79955p AD=7.79955p
+ PS=47.945u PD=47.945u rfmode=0
M$748 \$171 vbp bb2 gnd sg13_lv_nmos L=0.13u W=0.15u AS=0.1005p AD=0.1005p
+ PS=1.34u PD=1.34u rfmode=0
M$749 bb3 vbp \$177 gnd sg13_lv_nmos L=0.13u W=0.31u AS=0.1054p AD=0.1054p
+ PS=1.3u PD=1.3u rfmode=0
M$750 \$177 g3 \$172 gnd sg13_lv_nmos L=0.13u W=77.5u AS=15.1p AD=15.1p
+ PS=92.08u PD=92.08u rfmode=0
M$781 \$172 vbp bb3 gnd sg13_lv_nmos L=0.13u W=0.31u AS=0.1054p AD=0.1054p
+ PS=1.3u PD=1.3u rfmode=0
M$782 bb4 vbp \$178 gnd sg13_lv_nmos L=0.13u W=0.62u AS=0.2108p AD=0.2108p
+ PS=1.92u PD=1.92u rfmode=0
M$783 \$178 g4 \$173 gnd sg13_lv_nmos L=0.13u W=154.38u AS=29.7057p AD=29.7057p
+ PS=180.73u PD=180.73u rfmode=0
M$845 \$173 vbp bb4 gnd sg13_lv_nmos L=0.13u W=0.62u AS=0.2108p AD=0.2108p
+ PS=1.92u PD=1.92u rfmode=0
R$846 bb5 \$14 gnd rhigh w=5u l=60.8u ps=0u b=0 m=1
R$847 bb5 \$11 gnd rhigh w=5u l=60.8u ps=0u b=0 m=1
R$848 bb6 \$15 gnd rhigh w=5u l=60.8u ps=0u b=0 m=1
R$849 bb6 \$12 gnd rhigh w=5u l=60.8u ps=0u b=0 m=1
R$850 bb7 \$16 gnd rhigh w=5u l=60.8u ps=0u b=0 m=1
R$851 bb7 \$13 gnd rhigh w=5u l=60.8u ps=0u b=0 m=1
R$852 bb8 \$85 gnd rhigh w=5u l=60.8u ps=0u b=0 m=1
R$853 bb8 \$81 gnd rhigh w=5u l=60.8u ps=0u b=0 m=1
R$854 bb9 \$86 gnd rhigh w=5u l=60.8u ps=0u b=0 m=1
R$855 bb9 \$82 gnd rhigh w=5u l=60.8u ps=0u b=0 m=1
R$856 bb10 \$87 gnd rhigh w=5u l=60.8u ps=0u b=0 m=1
R$857 bb10 \$83 gnd rhigh w=5u l=60.8u ps=0u b=0 m=1
R$858 bb11 \$88 gnd rhigh w=5u l=60.8u ps=0u b=0 m=1
R$859 bb11 \$84 gnd rhigh w=5u l=60.8u ps=0u b=0 m=1
R$860 bb0 \$174 gnd rhigh w=5u l=60.8u ps=0u b=0 m=1
R$861 bb0 \$169 gnd rhigh w=5u l=60.8u ps=0u b=0 m=1
R$862 bb1 \$175 gnd rhigh w=5u l=60.8u ps=0u b=0 m=1
R$863 bb1 \$170 gnd rhigh w=5u l=60.8u ps=0u b=0 m=1
R$864 bb2 \$176 gnd rhigh w=5u l=60.8u ps=0u b=0 m=1
R$865 bb2 \$171 gnd rhigh w=5u l=60.8u ps=0u b=0 m=1
R$866 bb3 \$177 gnd rhigh w=5u l=60.8u ps=0u b=0 m=1
R$867 bb3 \$172 gnd rhigh w=5u l=60.8u ps=0u b=0 m=1
R$868 bb4 \$178 gnd rhigh w=5u l=60.8u ps=0u b=0 m=1
R$869 bb4 \$173 gnd rhigh w=5u l=60.8u ps=0u b=0 m=1
C$870 tp \$174 cap_cmim w=2.81u l=2.81u A=7.8961p P=11.24u m=1
C$871 tp \$175 cap_cmim w=3.92u l=3.92u A=15.3664p P=15.68u m=1
C$872 tn \$170 cap_cmim w=3.92u l=3.92u A=15.3664p P=15.68u m=1
C$873 tn \$169 cap_cmim w=2.81u l=2.81u A=7.8961p P=11.24u m=1
C$874 tp \$176 cap_cmim w=5.53u l=5.53u A=30.5809p P=22.12u m=1
C$875 tn \$171 cap_cmim w=5.53u l=5.53u A=30.5809p P=22.12u m=1
C$876 tp \$88 gnd rfcmim w=15.71u l=15.71u A=246.8041p P=62.84u m=1 wfeed=5u
C$877 tp \$87 gnd rfcmim w=15.71u l=15.71u A=246.8041p P=62.84u m=1 wfeed=5u
C$878 tn \$82 gnd rfcmim w=15.71u l=15.71u A=246.8041p P=62.84u m=1 wfeed=5u
C$879 tn \$173 gnd rfcmim w=11.12u l=11.12u A=123.6544p P=44.48u m=1 wfeed=5u
C$880 tn \$83 gnd rfcmim w=15.71u l=15.71u A=246.8041p P=62.84u m=1 wfeed=5u
C$881 tn \$172 gnd rfcmim w=7.87u l=7.87u A=61.9369p P=31.48u m=1 wfeed=5u
C$882 tp \$178 gnd rfcmim w=11.12u l=11.12u A=123.6544p P=44.48u m=1 wfeed=5u
C$883 tn \$81 gnd rfcmim w=15.71u l=15.71u A=246.8041p P=62.84u m=1 wfeed=5u
C$884 tn \$11 gnd rfcmim w=15.71u l=15.71u A=246.8041p P=62.84u m=1 wfeed=5u
C$885 tp \$85 gnd rfcmim w=15.71u l=15.71u A=246.8041p P=62.84u m=1 wfeed=5u
C$886 tn \$84 gnd rfcmim w=15.71u l=15.71u A=246.8041p P=62.84u m=1 wfeed=5u
C$887 tp \$177 gnd rfcmim w=7.87u l=7.87u A=61.9369p P=31.48u m=1 wfeed=5u
C$888 tp \$16 gnd rfcmim w=15.71u l=15.71u A=246.8041p P=62.84u m=1 wfeed=5u
C$889 tp \$86 gnd rfcmim w=15.71u l=15.71u A=246.8041p P=62.84u m=1 wfeed=5u
C$890 tp \$14 gnd rfcmim w=15.71u l=15.71u A=246.8041p P=62.84u m=1 wfeed=5u
C$891 tp \$15 gnd rfcmim w=15.71u l=15.71u A=246.8041p P=62.84u m=1 wfeed=5u
C$892 tn \$12 gnd rfcmim w=15.71u l=15.71u A=246.8041p P=62.84u m=1 wfeed=5u
C$893 tn \$13 gnd rfcmim w=15.71u l=15.71u A=246.8041p P=62.84u m=1 wfeed=5u
.ENDS vco_bank
