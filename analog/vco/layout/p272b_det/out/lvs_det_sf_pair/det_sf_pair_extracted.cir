* Extracted by KLayout with SG13G2 LVS runset on : 16/11/2026 11:52

.SUBCKT det_sf_pair ct gnd hold rep tn tp vdd
M$1 gnd gnd gnd gnd sg13_lv_nmos L=0.13u W=1u AS=0.34p AD=0.34p PS=3.36u
+ PD=3.36u rfmode=0
M$2 vdd tp hold gnd sg13_lv_nmos L=0.13u W=0.5u AS=0.17p AD=0.17p PS=1.68u
+ PD=1.68u rfmode=0
M$3 vdd ct rep gnd sg13_lv_nmos L=0.13u W=1u AS=0.34p AD=0.34p PS=3.36u
+ PD=3.36u rfmode=0
M$5 vdd tn hold gnd sg13_lv_nmos L=0.13u W=0.5u AS=0.17p AD=0.17p PS=1.68u
+ PD=1.68u rfmode=0
.ENDS det_sf_pair
