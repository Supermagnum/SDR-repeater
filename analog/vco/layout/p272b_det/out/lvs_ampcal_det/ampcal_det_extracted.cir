* Extracted by KLayout with SG13G2 LVS runset on : 16/11/2026 23:06

.SUBCKT ampcal_det ct gnd hold|rep tn tp vdd
M$1 \$4 \$3 gnd gnd sg13_lv_nmos L=0.13u W=2u AS=0.68p AD=0.68p PS=4.68u
+ PD=4.68u rfmode=0
M$2 \$5 \$3 gnd gnd sg13_lv_nmos L=0.13u W=2u AS=0.68p AD=0.68p PS=4.68u
+ PD=4.68u rfmode=0
M$3 \$6 \$3 gnd gnd sg13_lv_nmos L=0.13u W=2u AS=0.68p AD=0.68p PS=4.68u
+ PD=4.68u rfmode=0
M$4 \$7 \$3 gnd gnd sg13_lv_nmos L=0.13u W=2u AS=0.68p AD=0.68p PS=4.68u
+ PD=4.68u rfmode=0
M$5 \$8 \$3 gnd gnd sg13_lv_nmos L=0.13u W=2u AS=0.68p AD=0.68p PS=4.68u
+ PD=4.68u rfmode=0
M$6 hold|rep hold|rep \$4 gnd sg13_lv_nmos L=1u W=1u AS=0.34p AD=0.34p PS=2.68u
+ PD=2.68u rfmode=0
M$7 hold|rep hold|rep \$5 gnd sg13_lv_nmos L=1u W=1u AS=0.34p AD=0.34p PS=2.68u
+ PD=2.68u rfmode=0
M$8 hold|rep hold|rep \$6 gnd sg13_lv_nmos L=1u W=1u AS=0.34p AD=0.34p PS=2.68u
+ PD=2.68u rfmode=0
M$9 gnd gnd gnd gnd sg13_lv_nmos L=0.5u W=4u AS=1.36p AD=1.36p PS=9.36u
+ PD=9.36u rfmode=0
M$10 \$19 \$30 \$18 gnd sg13_lv_nmos L=0.5u W=4u AS=1.06p AD=1.06p PS=7.06u
+ PD=7.06u rfmode=0
M$12 \$20 \$31 \$18 gnd sg13_lv_nmos L=0.5u W=4u AS=1.06p AD=1.06p PS=7.06u
+ PD=7.06u rfmode=0
M$15 \$21 hold|rep \$7 gnd sg13_lv_nmos L=1u W=5.5u AS=1.4575p AD=1.4575p
+ PS=9.31u PD=9.31u rfmode=0
M$17 \$22 hold|rep \$8 gnd sg13_lv_nmos L=1u W=5.5u AS=1.4575p AD=1.4575p
+ PS=9.31u PD=9.31u rfmode=0
M$19 gnd gnd gnd gnd sg13_lv_nmos L=0.13u W=1u AS=0.34p AD=0.34p PS=3.36u
+ PD=3.36u rfmode=0
M$20 vdd tp \$36 gnd sg13_lv_nmos L=0.13u W=0.5u AS=0.17p AD=0.17p PS=1.68u
+ PD=1.68u rfmode=0
M$21 vdd ct \$37 gnd sg13_lv_nmos L=0.13u W=1u AS=0.34p AD=0.34p PS=3.36u
+ PD=3.36u rfmode=0
M$23 vdd tn \$36 gnd sg13_lv_nmos L=0.13u W=0.5u AS=0.17p AD=0.17p PS=1.68u
+ PD=1.68u rfmode=0
M$25 \$39 \$20 \$38 gnd sg13_lv_nmos L=0.5u W=4u AS=1.06p AD=1.06p PS=7.06u
+ PD=7.06u rfmode=0
M$27 \$40 \$19 \$38 gnd sg13_lv_nmos L=0.5u W=4u AS=1.06p AD=1.06p PS=7.06u
+ PD=7.06u rfmode=0
M$29 \$39 \$39 \$53 \$53 sg13_lv_pmos L=0.5u W=4u AS=1.06p AD=1.06p PS=7.06u
+ PD=7.06u rfmode=0
M$31 \$40 \$39 \$53 \$53 sg13_lv_pmos L=0.5u W=4u AS=1.06p AD=1.06p PS=7.06u
+ PD=7.06u rfmode=0
R$33 \$19 \$53 gnd rhigh w=0.5u l=6.96u ps=0u b=0 m=1
R$34 \$20 \$53 gnd rhigh w=0.5u l=6.96u ps=0u b=0 m=1
R$35 hold|rep \$61 gnd rhigh w=0.5u l=78u ps=0u b=0 m=1
C$36 hold|rep gnd cap_cmim w=16.27u l=16.27u A=264.7129p P=65.08u m=2
C$38 \$60 \$59 cap_cmim w=5.71u l=5.71u A=32.6041p P=22.84u m=1
.ENDS ampcal_det
