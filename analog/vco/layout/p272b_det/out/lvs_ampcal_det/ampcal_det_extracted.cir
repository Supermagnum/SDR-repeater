* Extracted by KLayout with SG13G2 LVS runset on : 17/11/2026 01:54

.SUBCKT ampcal_det cmp|en|gnd|hold|rep ct tn tp vdd vthn
M$1 \$6 cmp|en|gnd|hold|rep cmp|en|gnd|hold|rep cmp|en|gnd|hold|rep
+ sg13_lv_nmos L=0.13u W=2u AS=0.68p AD=0.68p PS=4.68u PD=4.68u rfmode=0
M$2 \$7 cmp|en|gnd|hold|rep cmp|en|gnd|hold|rep cmp|en|gnd|hold|rep
+ sg13_lv_nmos L=0.13u W=2u AS=0.68p AD=0.68p PS=4.68u PD=4.68u rfmode=0
M$3 \$8 cmp|en|gnd|hold|rep cmp|en|gnd|hold|rep cmp|en|gnd|hold|rep
+ sg13_lv_nmos L=0.13u W=2u AS=0.68p AD=0.68p PS=4.68u PD=4.68u rfmode=0
M$4 \$9 cmp|en|gnd|hold|rep cmp|en|gnd|hold|rep cmp|en|gnd|hold|rep
+ sg13_lv_nmos L=0.13u W=2u AS=0.68p AD=0.68p PS=4.68u PD=4.68u rfmode=0
M$5 \$10 cmp|en|gnd|hold|rep cmp|en|gnd|hold|rep cmp|en|gnd|hold|rep
+ sg13_lv_nmos L=0.13u W=2u AS=0.68p AD=0.68p PS=4.68u PD=4.68u rfmode=0
M$6 cmp|en|gnd|hold|rep cmp|en|gnd|hold|rep \$6 cmp|en|gnd|hold|rep
+ sg13_lv_nmos L=1u W=1u AS=0.34p AD=0.34p PS=2.68u PD=2.68u rfmode=0
M$7 cmp|en|gnd|hold|rep cmp|en|gnd|hold|rep \$7 cmp|en|gnd|hold|rep
+ sg13_lv_nmos L=1u W=1u AS=0.34p AD=0.34p PS=2.68u PD=2.68u rfmode=0
M$8 cmp|en|gnd|hold|rep cmp|en|gnd|hold|rep \$8 cmp|en|gnd|hold|rep
+ sg13_lv_nmos L=1u W=1u AS=0.34p AD=0.34p PS=2.68u PD=2.68u rfmode=0
M$9 cmp|en|gnd|hold|rep cmp|en|gnd|hold|rep cmp|en|gnd|hold|rep
+ cmp|en|gnd|hold|rep sg13_lv_nmos L=0.5u W=4u AS=1.36p AD=1.36p PS=9.36u
+ PD=9.36u rfmode=0
M$10 \$16 cmp|en|gnd|hold|rep cmp|en|gnd|hold|rep cmp|en|gnd|hold|rep
+ sg13_lv_nmos L=0.5u W=4u AS=1.06p AD=1.06p PS=7.06u PD=7.06u rfmode=0
M$12 \$17 vthn cmp|en|gnd|hold|rep cmp|en|gnd|hold|rep sg13_lv_nmos L=0.5u W=4u
+ AS=1.06p AD=1.06p PS=7.06u PD=7.06u rfmode=0
M$15 \$18 cmp|en|gnd|hold|rep \$9 cmp|en|gnd|hold|rep sg13_lv_nmos L=1u W=5.5u
+ AS=1.4575p AD=1.4575p PS=9.31u PD=9.31u rfmode=0
M$17 \$19 cmp|en|gnd|hold|rep \$10 cmp|en|gnd|hold|rep sg13_lv_nmos L=1u W=5.5u
+ AS=1.4575p AD=1.4575p PS=9.31u PD=9.31u rfmode=0
M$19 cmp|en|gnd|hold|rep cmp|en|gnd|hold|rep cmp|en|gnd|hold|rep
+ cmp|en|gnd|hold|rep sg13_lv_nmos L=0.13u W=1u AS=0.34p AD=0.34p PS=3.36u
+ PD=3.36u rfmode=0
M$20 vdd tp cmp|en|gnd|hold|rep cmp|en|gnd|hold|rep sg13_lv_nmos L=0.13u W=0.5u
+ AS=0.17p AD=0.17p PS=1.68u PD=1.68u rfmode=0
M$21 vdd ct cmp|en|gnd|hold|rep cmp|en|gnd|hold|rep sg13_lv_nmos L=0.13u W=1u
+ AS=0.34p AD=0.34p PS=3.36u PD=3.36u rfmode=0
M$23 vdd tn cmp|en|gnd|hold|rep cmp|en|gnd|hold|rep sg13_lv_nmos L=0.13u W=0.5u
+ AS=0.17p AD=0.17p PS=1.68u PD=1.68u rfmode=0
M$25 vdd \$17 cmp|en|gnd|hold|rep cmp|en|gnd|hold|rep sg13_lv_nmos L=0.5u W=4u
+ AS=1.06p AD=1.06p PS=7.06u PD=7.06u rfmode=0
M$27 cmp|en|gnd|hold|rep \$16 cmp|en|gnd|hold|rep cmp|en|gnd|hold|rep
+ sg13_lv_nmos L=0.5u W=4u AS=1.06p AD=1.06p PS=7.06u PD=7.06u rfmode=0
M$29 vdd vdd vdd vdd sg13_lv_pmos L=0.5u W=4u AS=1.06p AD=1.06p PS=7.06u
+ PD=7.06u rfmode=0
M$31 cmp|en|gnd|hold|rep vdd vdd vdd sg13_lv_pmos L=0.5u W=4u AS=1.06p AD=1.06p
+ PS=7.06u PD=7.06u rfmode=0
R$33 \$16 vdd cmp|en|gnd|hold|rep rhigh w=0.5u l=6.96u ps=0u b=0 m=1
R$34 \$17 vdd cmp|en|gnd|hold|rep rhigh w=0.5u l=6.96u ps=0u b=0 m=1
R$35 cmp|en|gnd|hold|rep vdd cmp|en|gnd|hold|rep rhigh w=0.5u l=78u ps=0u b=0
+ m=1
C$36 cmp|en|gnd|hold|rep cmp|en|gnd|hold|rep cap_cmim w=16.27u l=16.27u
+ A=264.7129p P=65.08u m=2
C$38 cmp|en|gnd|hold|rep \$49 cap_cmim w=5.71u l=5.71u A=32.6041p P=22.84u m=1
.ENDS ampcal_det
