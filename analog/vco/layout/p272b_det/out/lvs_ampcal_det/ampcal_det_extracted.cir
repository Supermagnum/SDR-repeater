* Extracted by KLayout with SG13G2 LVS runset on : 16/11/2026 17:36

.SUBCKT ampcal_det
M$1 \$3 \$2 \$1 \$1 sg13_lv_nmos L=0.13u W=2u AS=0.68p AD=0.68p PS=4.68u
+ PD=4.68u rfmode=0
M$2 \$4 \$2 \$1 \$1 sg13_lv_nmos L=0.13u W=2u AS=0.68p AD=0.68p PS=4.68u
+ PD=4.68u rfmode=0
M$3 \$5 \$2 \$1 \$1 sg13_lv_nmos L=0.13u W=2u AS=0.68p AD=0.68p PS=4.68u
+ PD=4.68u rfmode=0
M$4 \$6 \$2 \$1 \$1 sg13_lv_nmos L=0.13u W=2u AS=0.68p AD=0.68p PS=4.68u
+ PD=4.68u rfmode=0
M$5 \$7 \$2 \$1 \$1 sg13_lv_nmos L=0.13u W=2u AS=0.68p AD=0.68p PS=4.68u
+ PD=4.68u rfmode=0
M$6 \$1 \$1 \$3 \$1 sg13_lv_nmos L=1u W=1u AS=0.34p AD=0.34p PS=2.68u PD=2.68u
+ rfmode=0
M$7 \$1 \$1 \$4 \$1 sg13_lv_nmos L=1u W=1u AS=0.34p AD=0.34p PS=2.68u PD=2.68u
+ rfmode=0
M$8 \$1 \$1 \$5 \$1 sg13_lv_nmos L=1u W=1u AS=0.34p AD=0.34p PS=2.68u PD=2.68u
+ rfmode=0
M$9 \$1 \$1 \$1 \$1 sg13_lv_nmos L=0.5u W=4u AS=1.36p AD=1.36p PS=9.36u
+ PD=9.36u rfmode=0
M$10 \$17 \$1 \$1 \$1 sg13_lv_nmos L=0.5u W=4u AS=1.06p AD=1.06p PS=7.06u
+ PD=7.06u rfmode=0
M$12 \$18 \$26 \$1 \$1 sg13_lv_nmos L=0.5u W=4u AS=1.06p AD=1.06p PS=7.06u
+ PD=7.06u rfmode=0
M$15 \$1 \$1 \$6 \$1 sg13_lv_nmos L=1u W=5.5u AS=1.4575p AD=1.4575p PS=9.31u
+ PD=9.31u rfmode=0
M$17 \$1 \$1 \$7 \$1 sg13_lv_nmos L=1u W=5.5u AS=1.4575p AD=1.4575p PS=9.31u
+ PD=9.31u rfmode=0
M$19 \$31 \$18 \$1 \$1 sg13_lv_nmos L=0.5u W=4u AS=1.06p AD=1.06p PS=7.06u
+ PD=7.06u rfmode=0
M$21 \$32 \$17 \$1 \$1 sg13_lv_nmos L=0.5u W=4u AS=1.06p AD=1.06p PS=7.06u
+ PD=7.06u rfmode=0
M$23 \$1 \$1 \$1 \$1 sg13_lv_nmos L=0.13u W=1u AS=0.34p AD=0.34p PS=3.36u
+ PD=3.36u rfmode=0
M$24 \$36 \$35 \$1 \$1 sg13_lv_nmos L=0.13u W=0.5u AS=0.17p AD=0.17p PS=1.68u
+ PD=1.68u rfmode=0
M$25 \$36 \$37 \$1 \$1 sg13_lv_nmos L=0.13u W=1u AS=0.34p AD=0.34p PS=3.36u
+ PD=3.36u rfmode=0
M$27 \$36 \$38 \$1 \$1 sg13_lv_nmos L=0.13u W=0.5u AS=0.17p AD=0.17p PS=1.68u
+ PD=1.68u rfmode=0
M$29 \$31 \$31 \$1 \$1 sg13_lv_pmos L=0.5u W=4u AS=1.06p AD=1.06p PS=7.06u
+ PD=7.06u rfmode=0
M$31 \$32 \$31 \$1 \$1 sg13_lv_pmos L=0.5u W=4u AS=1.06p AD=1.06p PS=7.06u
+ PD=7.06u rfmode=0
R$33 \$17 \$1 \$1 rhigh w=0.5u l=6.96u ps=0u b=0 m=1
R$34 \$18 \$1 \$1 rhigh w=0.5u l=6.96u ps=0u b=0 m=1
R$35 \$1 \$52 \$1 rhigh w=0.5u l=78u ps=0u b=0 m=1
C$36 \$1 \$1 cap_cmim w=16.27u l=16.27u A=264.7129p P=65.08u m=2
C$38 \$51 \$50 cap_cmim w=5.71u l=5.71u A=32.6041p P=22.84u m=1
.ENDS ampcal_det
