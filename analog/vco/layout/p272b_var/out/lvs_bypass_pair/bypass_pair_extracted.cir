* Extracted by KLayout with SG13G2 LVS runset on : 14/11/2026 19:29

.SUBCKT bypass_pair gnd vbp vgn vgp vvb
M$1 vgp vbp vvb gnd sg13_lv_nmos L=0.13u W=5u AS=1.325p AD=1.325p PS=8.56u
+ PD=8.56u rfmode=0
M$3 vgn vbp vvb gnd sg13_lv_nmos L=0.13u W=5u AS=1.325p AD=1.325p PS=8.56u
+ PD=8.56u rfmode=0
.ENDS bypass_pair
