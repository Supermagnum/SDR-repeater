* P2.7.2b vco_var [SCH vco_var D11]; G1=vgp G2=vgn W=vt
.subckt vco_var tp tn W vbp gnd G1 G2
Cxcp tp G1 gnd rfcmim w=21.29u l=21.29u wfeed=5u m=1
Cxcn tn G2 gnd rfcmim w=21.29u l=21.29u wfeed=5u m=1
Rrvp G1 vvb gnd rhigh w=0.5u l=42.095u ps=0.18u b=16 m=1
Rrvn G2 vvb gnd rhigh w=0.5u l=42.095u ps=0.18u b=16 m=1
Cxv1 G1 W G2 gnd sg13_hv_svaricap w=3.74u l=0.3u Nx=10
Cxv2 G1 W G2 gnd sg13_hv_svaricap w=3.74u l=0.3u Nx=10
Mmbp_rvp G1 vbp vvb gnd sg13_lv_nmos w=5.0u l=0.13u ng=2
Mmbp_rvn G2 vbp vvb gnd sg13_lv_nmos w=5.0u l=0.13u ng=2
.ends
