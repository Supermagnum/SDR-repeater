** sch_path: /work/analog/vco/sch/vco_sim_flat.sch
**.subckt vco_sim_flat tp tn ct vt vdd gnd vbp vbp_tail
*.iopin tp
*.iopin tn
*.iopin ct
*.iopin vt
*.iopin vdd
*.iopin gnd
*.iopin vbp
*.iopin vbp_tail
r1p p p1 0.814837
l1p p1 p2 8.05663e-10
r2p p2 ct 0.827877
l2p p2 ct 3.196e-11
r1n n n1 0.814837
l1n n1 n2 8.05663e-10
r2n n2 ct 0.827877
l2n n2 ct 3.196e-11
cp p n 2.98589e-14
Xm1 tp tn tail gnd sg13_lv_nmos w=32u l=0.13u ng=8 m=1 mm_ok=1
Xm2 tn tp tail gnd sg13_lv_nmos w=32u l=0.13u ng=8 m=1 mm_ok=1
Xxf1 tp fx gnd cap_rfcmim w=1.640200e-05 l=1.640200e-05 wfeed=5.0e-6 m=1 mm_ok=1
Xxf2 tn fx gnd cap_rfcmim w=1.640200e-05 l=1.640200e-05 wfeed=5.0e-6 m=1 mm_ok=1
rfx fx gnd 200000.0
Xxb0p tp a0 gnd cap_rfcmim w=2.844000e-06 l=2.844000e-06 wfeed=5.0e-6 m=1 mm_ok=1
Xxb0n tn b0 gnd cap_rfcmim w=2.844000e-06 l=2.844000e-06 wfeed=5.0e-6 m=1 mm_ok=1
Xms0 a0 g0 b0 gnd sg13_lv_nmos w=10.11u l=0.13u ng=4 m=1 mm_ok=1
rba0 a0 bb0 2000000.0
rbb0 b0 bb0 2000000.0
Xmbp_rba0 a0 vbp bb0 gnd sg13_lv_nmos w=5u l=0.13u ng=2 m=1 mm_ok=1
Xmbp_rbb0 b0 vbp bb0 gnd sg13_lv_nmos w=5u l=0.13u ng=2 m=1 mm_ok=1
Xxb1p tp a1 gnd cap_rfcmim w=3.964000e-06 l=3.964000e-06 wfeed=5.0e-6 m=1 mm_ok=1
Xxb1n tn b1 gnd cap_rfcmim w=3.964000e-06 l=3.964000e-06 wfeed=5.0e-6 m=1 mm_ok=1
Xms1 a1 g1 b1 gnd sg13_lv_nmos w=19.64u l=0.13u ng=8 m=1 mm_ok=1
rba1 a1 bb1 2000000.0
rbb1 b1 bb1 2000000.0
Xmbp_rba1 a1 vbp bb1 gnd sg13_lv_nmos w=5u l=0.13u ng=2 m=1 mm_ok=1
Xmbp_rbb1 b1 vbp bb1 gnd sg13_lv_nmos w=5u l=0.13u ng=2 m=1 mm_ok=1
Xxb2p tp a2 gnd cap_rfcmim w=5.564000e-06 l=5.564000e-06 wfeed=5.0e-6 m=1 mm_ok=1
Xxb2n tn b2 gnd cap_rfcmim w=5.564000e-06 l=5.564000e-06 wfeed=5.0e-6 m=1 mm_ok=1
Xms2 a2 g2 b2 gnd sg13_lv_nmos w=38.70u l=0.13u ng=15 m=1 mm_ok=1
rba2 a2 bb2 2000000.0
rbb2 b2 bb2 2000000.0
Xmbp_rba2 a2 vbp bb2 gnd sg13_lv_nmos w=5u l=0.13u ng=2 m=1 mm_ok=1
Xmbp_rbb2 b2 vbp bb2 gnd sg13_lv_nmos w=5u l=0.13u ng=2 m=1 mm_ok=1
Xxb3p tp a3 gnd cap_rfcmim w=7.841000e-06 l=7.841000e-06 wfeed=5.0e-6 m=1 mm_ok=1
Xxb3n tn b3 gnd cap_rfcmim w=7.841000e-06 l=7.841000e-06 wfeed=5.0e-6 m=1 mm_ok=1
Xms3 a3 g3 b3 gnd sg13_lv_nmos w=76.85u l=0.13u ng=31 m=1 mm_ok=1
rba3 a3 bb3 2000000.0
rbb3 b3 bb3 2000000.0
Xmbp_rba3 a3 vbp bb3 gnd sg13_lv_nmos w=5u l=0.13u ng=2 m=1 mm_ok=1
Xmbp_rbb3 b3 vbp bb3 gnd sg13_lv_nmos w=5u l=0.13u ng=2 m=1 mm_ok=1
Xxb4p tp a4 gnd cap_rfcmim w=1.107500e-05 l=1.107500e-05 wfeed=5.0e-6 m=1 mm_ok=1
Xxb4n tn b4 gnd cap_rfcmim w=1.107500e-05 l=1.107500e-05 wfeed=5.0e-6 m=1 mm_ok=1
Xms4 a4 g4 b4 gnd sg13_lv_nmos w=153.32u l=0.13u ng=61 m=1 mm_ok=1
rba4 a4 bb4 2000000.0
rbb4 b4 bb4 2000000.0
Xmbp_rba4 a4 vbp bb4 gnd sg13_lv_nmos w=5u l=0.13u ng=2 m=1 mm_ok=1
Xmbp_rbb4 b4 vbp bb4 gnd sg13_lv_nmos w=5u l=0.13u ng=2 m=1 mm_ok=1
Xxb5p tp a5 gnd cap_rfcmim w=1.565200e-05 l=1.565200e-05 wfeed=5.0e-6 m=1 mm_ok=1
Xxb5n tn b5 gnd cap_rfcmim w=1.565200e-05 l=1.565200e-05 wfeed=5.0e-6 m=1 mm_ok=1
Xms5 a5 g5 b5 gnd sg13_lv_nmos w=306.21u l=0.13u ng=122 m=1 mm_ok=1
rba5 a5 bb5 2000000.0
rbb5 b5 bb5 2000000.0
Xmbp_rba5 a5 vbp bb5 gnd sg13_lv_nmos w=5u l=0.13u ng=2 m=1 mm_ok=1
Xmbp_rbb5 b5 vbp bb5 gnd sg13_lv_nmos w=5u l=0.13u ng=2 m=1 mm_ok=1
Xxb6p tp a6 gnd cap_rfcmim w=2.208500e-05 l=2.208500e-05 wfeed=5.0e-6 m=1 mm_ok=1
Xxb6n tn b6 gnd cap_rfcmim w=2.208500e-05 l=2.208500e-05 wfeed=5.0e-6 m=1 mm_ok=1
Xms6 a6 g6 b6 gnd sg13_lv_nmos w=609.70u l=0.13u ng=244 m=1 mm_ok=1
rba6 a6 bb6 2000000.0
rbb6 b6 bb6 2000000.0
Xmbp_rba6 a6 vbp bb6 gnd sg13_lv_nmos w=5u l=0.13u ng=2 m=1 mm_ok=1
Xmbp_rbb6 b6 vbp bb6 gnd sg13_lv_nmos w=5u l=0.13u ng=2 m=1 mm_ok=1
Xxb7p tp a7 gnd cap_rfcmim w=3.107700e-05 l=3.107700e-05 wfeed=5.0e-6 m=1 mm_ok=1
Xxb7n tn b7 gnd cap_rfcmim w=3.107700e-05 l=3.107700e-05 wfeed=5.0e-6 m=1 mm_ok=1
Xms7 a7 g7 b7 gnd sg13_lv_nmos w=1207.23u l=0.13u ng=483 m=1 mm_ok=1
rba7 a7 bb7 2000000.0
rbb7 b7 bb7 2000000.0
Xmbp_rba7 a7 vbp bb7 gnd sg13_lv_nmos w=5u l=0.13u ng=2 m=1 mm_ok=1
Xmbp_rbb7 b7 vbp bb7 gnd sg13_lv_nmos w=5u l=0.13u ng=2 m=1 mm_ok=1
Xxcp tp vgp gnd cap_rfcmim w=2.129200e-05 l=2.129200e-05 wfeed=5.0e-6 m=1 mm_ok=1
Xxcn tn vgn gnd cap_rfcmim w=2.129200e-05 l=2.129200e-05 wfeed=5.0e-6 m=1 mm_ok=1
rvp vgp vvb 2000000.0
rvn vgn vvb 2000000.0
vvb vvb gnd 0.3
Xxv1 vgn vt vgp sub! sg13_hv_svaricap_fx w=3.74u l=0.3u Nx=10 mm_ok=1
Xxv2 vgn vt vgp sub! sg13_hv_svaricap_fx w=3.74u l=0.3u Nx=10 mm_ok=1
Xmbp_rvp vgp vbp vvb gnd sg13_lv_nmos w=5u l=0.13u ng=2 m=1 mm_ok=1
Xmbp_rvn vgn vbp vvb gnd sg13_lv_nmos w=5u l=0.13u ng=2 m=1 mm_ok=1
ctail tail gnd 8e-12
Xmt tail nbf gnd gnd sg13_lv_nmos w=160u l=4u ng=32 m=1 mm_ok=1
rbf nb nbf 1000000.0
cbf nbf gnd 5e-11
Xmr nb nb gnd gnd sg13_lv_nmos w=20u l=4u ng=4 m=1 mm_ok=1
iref vdd nb 0.0005
Xmbp_rbf nb vbp_tail nbf gnd sg13_lv_nmos w=20u l=0.13u ng=4 m=1 mm_ok=1
Xmb1 op tp tb gnd sg13_lv_nmos w=10u l=0.13u ng=4 m=1 mm_ok=1
Xmb2 on tn tb gnd sg13_lv_nmos w=10u l=0.13u ng=4 m=1 mm_ok=1
rl1 vdd op 400
rl2 vdd on 400
ib tb gnd 0.001
ctb tb gnd 2e-12
cl1 op gnd 2e-14
cl2 on gnd 2e-14
**.ends
.end
