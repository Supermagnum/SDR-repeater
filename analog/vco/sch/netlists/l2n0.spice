** sch_path: /work/analog/vco/sch/l2n0.sch
**.subckt l2n0 p n ct
*.iopin p
*.iopin n
*.iopin ct
r1p p p1 0.814837
l1p p1 p2 8.05663e-10
r2p p2 ct 0.827877
l2p p2 ct 3.196e-11
r1n n n1 0.814837
l1n n1 n2 8.05663e-10
r2n n2 ct 0.827877
l2n n2 ct 3.196e-11
cp p n 2.98589e-14
**.ends
.end
